ADE simulation setup
Run mode: Single Run, Sweeps and Corners
Tests:
  ece483_sp23_current_1: ece483_sp23/current/schematic, simulator spectre
