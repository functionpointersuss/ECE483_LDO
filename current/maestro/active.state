ADE simulation setup
Test ece483_sp23_current_1: ece483_sp23/current/schematic, simulator spectre
  Models: /class/ece483/models/models_ece483
  Temperature: 27
  Analysis dc: (saves the operating point)
  Output vg = VDC("/N0/G")
  Output IDC("/N0/D")
  Output OP("/N0" "vgt")
  Signals: /N0/G (terminal) as /N0/G_V, /N0/D (terminal)
Run mode: Single Run, Sweeps and Corners
