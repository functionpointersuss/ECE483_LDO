ADE simulation setup
Test ece483_sp23_milosh_1: ece483_sp23/milosh/schematic, simulator spectre
  Models: /class/ece483/models/models_ece483
  Variables: lp = 540n; wp = 540n
  Temperature: 27
  Analysis dc: (saves the operating point)
  Output VDC("/vbp1")
  Output IDC("/I0/PLUS")
  Signals: /I0/PLUS (terminal)
Run mode: Single Run, Sweeps and Corners
