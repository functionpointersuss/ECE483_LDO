ADE simulation setup
Run mode: Single Run, Sweeps and Corners
Tests:
  ece483_sp23_milosh_1: ece483_sp23/milosh/schematic, simulator spectre
    Variables: lp = 540n; wp = 540n
