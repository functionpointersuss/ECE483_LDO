ADE simulation setup
Run mode: Single Run, Sweeps and Corners
Tests:
  ece483_sp23_telescopic_bias_tb_1: ece483_sp23/telescopic_bias_tb/schematic, simulator spectre
    Variables: lp = 540n; wp = 540n
    Outputs: (1 / OP("/I0/N12" "gds")); OP("/I0/N12" "vds"); vpb1 V
