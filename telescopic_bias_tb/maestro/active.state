ADE simulation setup
Test ece483_sp23_telescopic_bias_tb_1: ece483_sp23/telescopic_bias_tb/schematic, simulator spectre
  Models: /class/ece483/models/models_ece483
  Variables: lp = 540n; wp = 540n
  Temperature: 27
  Analysis dc: (saves the operating point)
  Output mirror I = IDC("/I0/P4/D")
  Output vbn I = IDC("/I0/P6/S")
  Output orig I = IDC("/I0/N0/D")
  Output vbp I = IDC("/I0/P7/S")
  Output vbn1 V = VDC("/vbn1")
  Output vpb1 V = VDC("/vbp1")
  Output VDC("/net1")
  Output IDC("/I0/N12/D")
  Output OP("/I0/N12" "vds")
  Output OP("/I0/N12" "vgt")
  Output VDC("/I0/mirror2")
  Signals: /I0/P4/D (terminal), /I0/P6/S (terminal), /I0/N0/D (terminal), /I0/P7/S (terminal), /I0/N12/D (terminal)
Run mode: Single Run, Sweeps and Corners
