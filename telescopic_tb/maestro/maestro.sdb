ADE simulation setup
Run mode: Single Run, Sweeps and Corners
Tests:
  ece483_sp23_telescopic_tb_1: ece483_sp23/telescopic_tb/schematic, simulator spectre
    Variables: lp = 10*180n; lengthn = 10*180n; wn = 11*10*180n; wp = 11*10*180n; vic = 0.6; CL = 200f; vdd = 1.8; vss = 0; ltail = 2*180n; wtail = 30*180n
    Outputs: Cascode Saturation; Gm Saturation; Tail Saturation; V tail
Specs:
  ece483_sp23_telescopic_tb_1 / A0: > 100
  ece483_sp23_telescopic_tb_1 / Tail Saturation: > 0
  ece483_sp23_telescopic_tb_1 / Cascode Saturation: > 0
  ece483_sp23_telescopic_tb_1 / Gm Saturation: > 0
