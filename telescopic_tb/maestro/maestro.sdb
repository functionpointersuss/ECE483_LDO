ADE simulation setup
Run mode: Single Run, Sweeps and Corners
Tests:
  ece483_sp23_telescopic_tb_1: ece483_sp23/telescopic_tb/schematic, simulator spectre
    Variables: lp = 2*12*180n; wp = 2*12*8*180n; wn = 3*12*11*180n; lengthn = 3*12*180n; vic = 0.8; CL = 200f; vdd = 1.8; vss = 0; ltail = 2*180n; wtail = 25*180n
    Outputs: Cascode Saturation; Gm Saturation; Tail Saturation; V tail; Cascode rds
Specs:
  ece483_sp23_telescopic_tb_1 / A0: > 100
  ece483_sp23_telescopic_tb_1 / Tail Saturation: > 0
  ece483_sp23_telescopic_tb_1 / Cascode Saturation: > 0
  ece483_sp23_telescopic_tb_1 / Gm Saturation: > 0
  ece483_sp23_telescopic_tb_1 / (OP("/I2/P5" "vds") - OP("/I2/P5" "vgt")): < 0
  ece483_sp23_telescopic_tb_1 / (OP("/I2/P1" "vds") - OP("/I2/P1" "vgt")): < 0
