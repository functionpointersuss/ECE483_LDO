ADE simulation setup
Test ece483_sp23_telescopic_tb_1: ece483_sp23/telescopic_tb/schematic, simulator spectre
  Models: /class/ece483/models/models_ece483
  Variables: lp = 10*180n; lengthn = 10*180n; wn = 11*10*180n; wp = 11*10*180n; vic = 0.6; CL = 200f; vdd = 1.8; vss = 0; ltail = 2*180n; wtail = 30*180n
  Temperature: 27
  Analysis dc: (saves the operating point)
  Analysis ac: start=1 stop=1G
  Output A = dB20(VF("/vout"))
  Output A0 = value(A 1)
  Output fugf = cross(A 0)
  Output Vout = VDC("/vout")
  Output V Between = VDC("/I2/net3")
  Output V tail = VDC("/I2/vbn_ib")
  Output V Bias N = VDC("/I2/vbn1")
  Output V Bias P = VDC("/I2/vbp1")
  Output I Bias P = IDC("/I2/N12/D")
  Output I Bias N = IDC("/I2/N11/D")
  Output Tail Saturation = (OP("/I2/N2" "vds") - OP("/I2/N2" "vgt"))
  Output Cascode Saturation = (OP("/I2/N0" "vds") - OP("/I2/N0" "vgt"))
  Output Gm Saturation = (OP("/I2/N3" "vds") - OP("/I2/N3" "vgt"))
  Output Gm Vov = OP("/I2/N3" "vgt")
  Output Gm I Bias = IDC("/I2/N0/D")
  Output Tail Current = IDC("/I2/N2/D")
  Output Cascode Vov = OP("/I2/N0" "vgt")
  Output Cascode Threshold = OP("/I2/N0" "vth")
  Output Gm gm = OP("/I2/N3" "gm")
  Signals: /I2/N12/D (terminal), /I2/N11/D (terminal), /I2/N0/D (terminal), /I2/N2/D (terminal)
Run mode: Single Run, Sweeps and Corners
Specs:
  ece483_sp23_telescopic_tb_1 / A0: > 100
  ece483_sp23_telescopic_tb_1 / Tail Saturation: > 0
  ece483_sp23_telescopic_tb_1 / Cascode Saturation: > 0
  ece483_sp23_telescopic_tb_1 / Gm Saturation: > 0
