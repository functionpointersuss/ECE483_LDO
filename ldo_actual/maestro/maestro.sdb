ADE simulation setup
Run mode: Single Run, Sweeps and Corners
Tests:
  ece483_sp23_ldo_actual_1: ece483_sp23/ldo_actual/schematic, simulator spectre
    Variables: Cout = 200p; Iload = 10m; wn = 3*12*11*180n; lengthn = 3*12*180n; wp = 2*12*11*180n; lp = 2*12*180n; Lp = 180n; Rf1 = 7.5k; Rf2 = 7.5k; VIN = 1.8; vin = 1; VREF = 0.6; vref = 0; Wp = 18u; wtail = 25*180n; ltail = 2*180n
    Outputs: Load Regulation Val; cross(db(mag(getData("loopGain" ?result "stb"))) 0); VF("/Vout"); dB20(VF("/Vout"))
