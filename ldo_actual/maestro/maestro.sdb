ADE simulation setup
Run mode: Single Run, Sweeps and Corners
Tests:
  ece483_sp23_ldo_actual_1: ece483_sp23/ldo_actual/schematic, simulator spectre
    Variables: Cout = 200p; Iload = 1m; lengthn = 10*180n; Lp = 270n; lp = 10*180n; ltail = 2*180n; Rf1 = 7.5k; Rf2 = 7.5k; VIN = 1.8; vin = 1; VREF = 0.6; vref = 0; wn = 11*10*180n; Wp = 50u; wp = 11*10*180n; wtail = 30*180n
    Outputs: ymax(abs(deriv(VS("/Vout"))))
