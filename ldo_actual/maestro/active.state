ADE simulation setup
Test ece483_sp23_ldo_actual_1: ece483_sp23/ldo_actual/schematic, simulator spectre
  Models: /class/ece483/models/models_ece483
  Variables: Cout = 200p; Iload = 1m; lengthn = 10*180n; Lp = 270n; lp = 10*180n; ltail = 2*180n; Rf1 = 7.5k; Rf2 = 7.5k; VIN = 1.8; vin = 1; VREF = 0.6; vref = 0; wn = 11*10*180n; Wp = 50u; wp = 11*10*180n; wtail = 30*180n
  Temperature: 27
  Analysis dc: sweep Iload start=0.1m stop=10m (saves the operating point)
  Analysis ac: start=1 stop=10G
  Analysis tran: stop=20u errpreset=moderate
  Analysis stb: start=1 stop=10G probe=/VSTB stbProbeMode=differential
  Output Loop Gain Phase = phaseDegUnwrapped(getData("loopGain" ?result "stb"))
  Output Loop Gain db20 = db(mag(getData("loopGain" ?result "stb")))
  Output Phase Margin = getData("phaseMargin" ?result "stb_margin")
  Output Gain Margin = getData("gainMargin" ?result "stb_margin")
  Output Vout_tran = VT("/Vout")
  Output IT("/Rload/PLUS")
  Output Line Load Regulation = deriv(VS("/Vout"))
  Output ymax(abs(deriv(VS("/Vout"))))
  Output rdsp = (1 / OP("/P0" "gds"))
  Output Pass in Saturation = (abs(OP("/P0" "vds")) - abs(OP("/P0" "vgt")))
  Output Quiescent = IDC("/V4/PLUS")
  Signals: /Rload/PLUS (terminal), /V4/PLUS (terminal)
Run mode: Single Run, Sweeps and Corners
Setup values for test ece483_sp23_ldo_actual_1: Iload = 10m; wn = 3*12*11*180n; lengthn = 3*12*180n; wp = 2*12*11*180n; lp = 2*12*180n; Lp = 180n; Wp = 18u; wtail = 25*180n
