ADE simulation setup
Test ece483_sp23_ldo_actual_1: ece483_sp23/ldo_actual/schematic, simulator spectre
  Models: /class/ece483/models/models_ece483
  Variables: Cout = 200p; Iload = 10m; wn = 3*12*11*180n; lengthn = 3*12*180n; wp = 2*12*11*180n; lp = 2*12*180n; Lp = 180n; Rf1 = 7.5k; Rf2 = 7.5k; VIN = 1.8; vin = 1; VREF = 0.6; vref = 0; Wp = 18u; wtail = 25*180n; ltail = 2*180n
  Temperature: 27
  Analysis stb: start=1 stop=10G probe=/VSTB stbProbeMode=differential
  Analysis tran: stop=20u errpreset=moderate
  Analysis ac: start=1 stop=10G
  Analysis dc: sweep Iload start=0.1m stop=10m (saves the operating point)
  Output Loop Gain Phase = phaseDegUnwrapped(getData("loopGain" ?result "stb"))
  Output Loop Gain db20 = db(mag(getData("loopGain" ?result "stb")))
  Output Phase Margin = getData("phaseMargin" ?result "stb_margin")
  Output Gain Margin = getData("gainMargin" ?result "stb_margin")
  Output Vout_tran = VT("/Vout")
  Output IT("/Rload/PLUS") (unticked)
  Output Line Load Regulation = deriv(VS("/Vout"))
  Output Load Regulation Val = ymax(abs(deriv(VS("/Vout"))))
  Output rdsp = (1 / OP("/P0" "gds"))
  Output Pass in Saturation = (abs(OP("/P0" "vds")) - abs(OP("/P0" "vgt")))
  Output Quiescent = IDC("/V4/PLUS")
  Output dB20(VF("/Vout"))
  Output OP("/I4/N3" "vgt")
  Output cross(db(mag(getData("loopGain" ?result "stb"))) 0)
  Signals: /Rload/PLUS (terminal), /V4/PLUS (terminal)
Run mode: Single Run, Sweeps and Corners
