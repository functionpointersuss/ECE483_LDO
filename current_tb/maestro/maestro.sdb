ADE simulation setup
Run mode: Single Run, Sweeps and Corners
Tests:
  ece483_sp23_current_tb_1: ece483_sp23/current_tb/schematic, simulator spectre
    Outputs: IDC("/I0/P0/S")
