ADE simulation setup
Test ece483_sp23_current_tb_1: ece483_sp23/current_tb/schematic, simulator spectre
  Models: /class/ece483/models/models_ece483
  Temperature: 27
  Analysis dc: (saves the operating point)
  Output VDC("/vovp")
  Output VDC("/vovn")
  Output OP("/I0/N0" "vgt")
  Output OP("/I0/P0" "vgt")
  Output IDC("/I0/N0/D")
  Output IDC("/I0/P0/S")
  Signals: /I0/N0/D (terminal), /I0/P0/S (terminal)
Run mode: Single Run, Sweeps and Corners
