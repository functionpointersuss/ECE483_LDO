ADE simulation setup
Test ece483_sp23_ldo_model_1: ece483_sp23/ldo_model/schematic, simulator spectre
  Models: /class/ece483/models/models_ece483
  Variables: Lp = 270n; Wp = 50u; Aea = 200k; Co1 = 100f; Cout = 200p; Gm1 = 2m; Iload = 1m; Rf1 = 7.5k; Rf2 = 7.5k; VIN = 1.8; vin = 0; VREF = 0.6; vref = 0
  Temperature: 27
  Analysis stb: start=1 stop=10G probe=/VSTB stbProbeMode=differential
  Analysis tran: stop=20u errpreset=moderate
  Analysis dc: sweep VIN start=1.72 stop=1.98 (saves the operating point)
  Output Loop Gain Phase = phaseDegUnwrapped(getData("loopGain" ?result "stb"))
  Output Loop Gain dB20 = db(mag(getData("loopGain" ?result "stb")))
  Output Phase Margin = getData("phaseMargin" ?result "stb_margin")
  Output Gain Margin = getData("gainMargin" ?result "stb_margin")
  Output Vout_tran = VT("/Vout")
  Output IT("/Rload/PLUS")
  Output Load Regulation = deriv(IS("/Rload/PLUS")) (unticked)
  Output ymax(deriv(IS("/Rload/PLUS")))
  Output Line Regulation = deriv(VS("/Vout")) (unticked)
  Output ymax(deriv(VS("/Vout")))
  Output rdsp = (1 / OP("/P0" "gds"))
  Output (abs(OP("/P0" "vds")) - abs(OP("/P0" "vgt")))
  Output Quiescent = IDC("/V4/PLUS")
  Signals: /Rload/PLUS (terminal), /I3/gnd! (terminal), /V4/PLUS (terminal)
Run mode: Single Run, Sweeps and Corners
Specs:
  ece483_sp23_ldo_model_1 / Pass in Saturation: > 0
  ece483_sp23_ldo_model_1 / ymax(deriv(VS("/Vout"))): < 500u
  ece483_sp23_ldo_model_1 / ymax(deriv(IS("/Rload/PLUS"))): < 50m
Setup values for test ece483_sp23_ldo_model_1: Aea = 14421; Gm1 = 129.5u
