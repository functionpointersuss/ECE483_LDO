ADE simulation setup
Run mode: Single Run, Sweeps and Corners
Tests:
  ece483_sp23_ldo_model_1: ece483_sp23/ldo_model/schematic, simulator spectre
    Variables: Aea = 200k; Co1 = 100f; Cout = 200p; Gm1 = 2m; Iload = 1m; Rf1 = 7.5k; Rf2 = 7.5k; VIN = 1.8; vin = 0; VREF = 0.6; vref = 0; Lp = 270n; Wp = 50u
    Outputs: Vout_tran; ymax(Line Regulation); ymax(Load Regulation); ymax("linereg"); ymax("loadreg"); nil; ymax(deriv(IS("/Rload/PLUS"))); deriv(IS("/Rload/PLUS")); Load Regulation; deriv(deriv(VS("/Vout"))); ymax(deriv(VS("/Vout"))); Line Regulation; Quiescent; (let ((in deriv(phaseDegUnwrapped(getData("loopGain" ?result "stb")))) setSGq(in 'log xScale) in))
Specs:
  ece483_sp23_ldo_model_1 / (abs(OP("/P0" "vds")) - abs(OP("/P0" "vgt"))): > 0
  ece483_sp23_ldo_model_1 / ymax(deriv(VS("/Vout"))): < 500u
  ece483_sp23_ldo_model_1 / ymax(deriv(IS("/Rload/PLUS"))): < 50m
